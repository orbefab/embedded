* led-5v: generated by packages/engine/scripts/ngspice_refs.py from netlist.json. Do not edit.
.options temp=25 tnom=25 reltol=1e-9 abstol=1e-15 vntol=1e-12 gmin=1e-12
dled1 vled 0 dmod_led1
.model dmod_led1 d (is=6.711e-10 n=4.427 rs=2.115)
rr1 vin vled 220.0
vv1 vin 0 dc 5.0
* The engine's gmin on every node, beside the gmin ngspice puts across each junction.
rx_gmin_vin vin 0 1000000000000.0
rx_gmin_vled vled 0 1000000000000.0
.control
save all @dled1[id] @rr1[i]
op
set filetype=ascii
write op.raw all
.endc
.end

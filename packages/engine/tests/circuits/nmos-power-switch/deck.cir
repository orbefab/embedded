* nmos-power-switch: generated by packages/engine/scripts/ngspice_refs.py from netlist.json. Do not edit.
.options temp=25 tnom=25 reltol=1e-9 abstol=1e-15 vntol=1e-12 gmin=1e-12
vx_m1_d d1 x_m1_d dc 0
vx_m1_g g x_m1_g dc 0
mm1 x_m1_d x_m1_g 0 0 mmod_m1 l=100u w=100u
.model mmod_m1 nmos (level=1 vto=3.18 kp=1.259 lambda=0.0014 is=0)
cm1_gs x_m1_g 0 3.26e-10
cm1_gd x_m1_g x_m1_d 3.4e-11
cm1_ds x_m1_d 0 1.16e-10
vx_m2_d d2 x_m2_d dc 0
vx_m2_g g x_m2_g dc 0
mm2 x_m2_d x_m2_g 0 0 mmod_m2 l=100u w=100u
.model mmod_m2 nmos (level=1 vto=3.18 kp=1.259 lambda=0.0014 is=0)
cm2_gs x_m2_g 0 3.26e-10
cm2_gd x_m2_g x_m2_d 3.4e-11
cm2_ds x_m2_d 0 1.16e-10
rrg pin g 100.0
rrl1 vcc d1 10.0
rrl2 vcc d2 1.0
vv1 vcc 0 dc 5.0
vvpin pin 0 dc 0.0 pwl(0p 0.0 1000000000p 0.0 1000001000p 5.0 3000000000p 5.0 3000001000p 0.0)
* The engine's gmin on every node, beside the gmin ngspice puts across each junction.
rx_gmin_vcc vcc 0 1000000000000.0
rx_gmin_pin pin 0 1000000000000.0
rx_gmin_g g 0 1000000000000.0
rx_gmin_d1 d1 0 1000000000000.0
rx_gmin_d2 d2 0 1000000000000.0
* One source per ramp corner makes it a breakpoint. ngspice skips a PWL corner it lands on an ulp early.
vbp0 bp0 0 pwl(1000000000p 0 1000000001p 0)
vbp1 bp1 0 pwl(1000001000p 0 1000001001p 0)
vbp2 bp2 0 pwl(3000000000p 0 3000000001p 0)
vbp3 bp3 0 pwl(3000001000p 0 3000001001p 0)
.control
save v(vcc) v(pin) v(g) v(d1) v(d2) i(vv1) i(vvpin) i(vx_m1_d) i(vx_m1_g) i(vx_m2_d) i(vx_m2_g) @rrg[i] @rrl1[i] @rrl2[i]
tran 5000000p 5000000000p 0 5000000p
set filetype=ascii
write tran.raw
.endc
.end

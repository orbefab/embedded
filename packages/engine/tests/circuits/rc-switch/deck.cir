* rc-switch: generated by packages/engine/scripts/ngspice_refs.py from netlist.json. Do not edit.
.options temp=25 tnom=25 reltol=1e-9 abstol=1e-15 vntol=1e-12 gmin=1e-12
cc1 vout 0 1e-06
rr1 vsw vout 10000.0
rr2 vout 0 10000.0
ssw1 vin vsw ctl_sw1 0 swmod_sw1
.model swmod_sw1 sw (vt=0.5 vh=0 ron=0.1 roff=1000000000.0)
vctl_sw1 ctl_sw1 0 pwl(0p 0 1000000000p 0 1000001000p 1 31000000000p 1 31000001000p 0)
vv1 vin 0 dc 5.0
* One source per ramp corner makes it a breakpoint. ngspice skips a PWL corner it lands on an ulp early.
vbp0 bp0 0 pwl(1000000000p 0 1000000001p 0)
vbp1 bp1 0 pwl(1000001000p 0 1000001001p 0)
vbp2 bp2 0 pwl(31000000000p 0 31000000001p 0)
vbp3 bp3 0 pwl(31000001000p 0 31000001001p 0)
.control
save v(vin) v(vsw) v(vout) i(vv1) @cc1[i] @rr1[i] @rr2[i] @ssw1[i]
tran 81000000p 81000000000p 0 81000000p
set filetype=ascii
write tran.raw
.endc
.end

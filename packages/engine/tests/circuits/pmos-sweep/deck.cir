* pmos-sweep: generated by packages/engine/scripts/ngspice_refs.py from netlist.json. Do not edit.
.options temp=25 tnom=25 reltol=1e-9 abstol=1e-15 vntol=1e-12 gmin=1e-12
vx_m1_d d x_m1_d dc 0
vx_m1_g g x_m1_g dc 0
mm1 x_m1_d x_m1_g src src mmod_m1 l=100u w=100u
.model mmod_m1 pmos (level=1 vto=-0.8 kp=4.579 lambda=0.0 is=0)
cm1_gs x_m1_g src 7.23e-10
cm1_gd x_m1_g x_m1_d 5.6e-11
cm1_ds x_m1_d src 6.5e-11
rrg pin g 100.0
rrl d 0 100.0
vvpin pin 0 dc 5.0 pwl(0p 5.0 1000000000p 5.0 1000001000p 4.5 2000000000p 4.5 2000001000p 4.0 3000000000p 4.0 3000001000p 3.5 4000000000p 3.5 4000001000p 3.0 5000000000p 3.0 5000001000p 2.5 6000000000p 2.5 6000001000p 2.0 7000000000p 2.0 7000001000p 1.5 8000000000p 1.5 8000001000p 1.0 9000000000p 1.0 9000001000p 0.5 10000000000p 0.5 10000001000p 0.0)
vvsrc src 0 dc 5.0
* The engine's gmin on every node, beside the gmin ngspice puts across each junction.
rx_gmin_d d 0 1000000000000.0
rx_gmin_g g 0 1000000000000.0
rx_gmin_pin pin 0 1000000000000.0
rx_gmin_src src 0 1000000000000.0
* One source per ramp corner makes it a breakpoint. ngspice skips a PWL corner it lands on an ulp early.
vbp0 bp0 0 pwl(1000000000p 0 1000000001p 0)
vbp1 bp1 0 pwl(1000001000p 0 1000001001p 0)
vbp2 bp2 0 pwl(2000000000p 0 2000000001p 0)
vbp3 bp3 0 pwl(2000001000p 0 2000001001p 0)
vbp4 bp4 0 pwl(3000000000p 0 3000000001p 0)
vbp5 bp5 0 pwl(3000001000p 0 3000001001p 0)
vbp6 bp6 0 pwl(4000000000p 0 4000000001p 0)
vbp7 bp7 0 pwl(4000001000p 0 4000001001p 0)
vbp8 bp8 0 pwl(5000000000p 0 5000000001p 0)
vbp9 bp9 0 pwl(5000001000p 0 5000001001p 0)
vbp10 bp10 0 pwl(6000000000p 0 6000000001p 0)
vbp11 bp11 0 pwl(6000001000p 0 6000001001p 0)
vbp12 bp12 0 pwl(7000000000p 0 7000000001p 0)
vbp13 bp13 0 pwl(7000001000p 0 7000001001p 0)
vbp14 bp14 0 pwl(8000000000p 0 8000000001p 0)
vbp15 bp15 0 pwl(8000001000p 0 8000001001p 0)
vbp16 bp16 0 pwl(9000000000p 0 9000000001p 0)
vbp17 bp17 0 pwl(9000001000p 0 9000001001p 0)
vbp18 bp18 0 pwl(10000000000p 0 10000000001p 0)
vbp19 bp19 0 pwl(10000001000p 0 10000001001p 0)
.control
save v(d) v(g) v(pin) v(src) i(vvpin) i(vvsrc) i(vx_m1_d) i(vx_m1_g) @rrg[i] @rrl[i]
tran 11000000p 11000000000p 0 11000000p
set filetype=ascii
write tran.raw
.endc
.end

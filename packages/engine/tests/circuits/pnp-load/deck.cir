* pnp-load: generated by packages/engine/scripts/ngspice_refs.py from netlist.json. Do not edit.
.options temp=25 tnom=25 reltol=1e-9 abstol=1e-15 vntol=1e-12 gmin=1e-12
vx_q1_c out x_q1_c dc 0
vx_q1_b b x_q1_b dc 0
qq1 x_q1_c x_q1_b vcc qmod_q1
.model qmod_q1 pnp (is=2.9e-15 bf=173.2 br=0.7185 nf=1.0 nr=1.0 vaf=100.0 rb=4.068 rc=1.041 re=0.495 cje=1e-11 cjc=4.5e-12 mje=0 mjc=0)
rrb pin b 1000.0
rrl out 0 100.0
rrup vcc b 10000.0
vv1 vcc 0 dc 5.0
vvpin pin 0 dc 0.0
* The engine's gmin on every node, beside the gmin ngspice puts across each junction.
rx_gmin_b b 0 1000000000000.0
rx_gmin_out out 0 1000000000000.0
rx_gmin_pin pin 0 1000000000000.0
rx_gmin_vcc vcc 0 1000000000000.0
.control
save all i(vx_q1_c) i(vx_q1_b) @rrb[i] @rrl[i] @rrup[i]
op
set filetype=ascii
write op.raw all
.endc
.end

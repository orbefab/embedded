* button-led: generated by packages/engine/scripts/ngspice_refs.py from netlist.json. Do not edit.
.options temp=25 tnom=25 reltol=1e-9 abstol=1e-15 vntol=1e-12 gmin=1e-12
dled1 vk vbtn dmod_led1
.model dmod_led1 d (is=6.711e-10 n=4.427 rs=2.115)
rr1 vcc vbtn 10000.0
rr2 vcc vk 220.0
ssw1 vbtn 0 ctl_sw1 0 swmod_sw1
.model swmod_sw1 sw (vt=0.5 vh=0 ron=0.1 roff=1000000000.0)
vctl_sw1 ctl_sw1 0 pwl(0p 0 2000000000p 0 2000001000p 1 2040015938p 1 2040016938p 0 2114234716p 0 2114235716p 1 2665597584p 1 2665598584p 0 2854176182p 0 2854177182p 1 12000000000p 1 12000001000p 0 12089763725p 0 12089764725p 1 12337840633p 1 12337841633p 0 12576192418p 0 12576193418p 1 12607405695p 1 12607406695p 0 12637715418p 0 12637716418p 1 12691361990p 1 12691362990p 0 12720009883p 0 12720010883p 1 12727823423p 1 12727824423p 0)
vv1 vcc 0 dc 5.0
* The engine's gmin on every node, beside the gmin ngspice puts across each junction.
rx_gmin_vcc vcc 0 1000000000000.0
rx_gmin_vk vk 0 1000000000000.0
rx_gmin_vbtn vbtn 0 1000000000000.0
* One source per ramp corner makes it a breakpoint. ngspice skips a PWL corner it lands on an ulp early.
vbp0 bp0 0 pwl(2000000000p 0 2000000001p 0)
vbp1 bp1 0 pwl(2000001000p 0 2000001001p 0)
vbp2 bp2 0 pwl(2040015938p 0 2040015939p 0)
vbp3 bp3 0 pwl(2040016938p 0 2040016939p 0)
vbp4 bp4 0 pwl(2114234716p 0 2114234717p 0)
vbp5 bp5 0 pwl(2114235716p 0 2114235717p 0)
vbp6 bp6 0 pwl(2665597584p 0 2665597585p 0)
vbp7 bp7 0 pwl(2665598584p 0 2665598585p 0)
vbp8 bp8 0 pwl(2854176182p 0 2854176183p 0)
vbp9 bp9 0 pwl(2854177182p 0 2854177183p 0)
vbp10 bp10 0 pwl(12000000000p 0 12000000001p 0)
vbp11 bp11 0 pwl(12000001000p 0 12000001001p 0)
vbp12 bp12 0 pwl(12089763725p 0 12089763726p 0)
vbp13 bp13 0 pwl(12089764725p 0 12089764726p 0)
vbp14 bp14 0 pwl(12337840633p 0 12337840634p 0)
vbp15 bp15 0 pwl(12337841633p 0 12337841634p 0)
vbp16 bp16 0 pwl(12576192418p 0 12576192419p 0)
vbp17 bp17 0 pwl(12576193418p 0 12576193419p 0)
vbp18 bp18 0 pwl(12607405695p 0 12607405696p 0)
vbp19 bp19 0 pwl(12607406695p 0 12607406696p 0)
vbp20 bp20 0 pwl(12637715418p 0 12637715419p 0)
vbp21 bp21 0 pwl(12637716418p 0 12637716419p 0)
vbp22 bp22 0 pwl(12691361990p 0 12691361991p 0)
vbp23 bp23 0 pwl(12691362990p 0 12691362991p 0)
vbp24 bp24 0 pwl(12720009883p 0 12720009884p 0)
vbp25 bp25 0 pwl(12720010883p 0 12720010884p 0)
vbp26 bp26 0 pwl(12727823423p 0 12727823424p 0)
vbp27 bp27 0 pwl(12727824423p 0 12727824424p 0)
.control
save v(vcc) v(vk) v(vbtn) i(vv1) @dled1[id] @rr1[i] @rr2[i] @ssw1[i]
tran 20000000p 20000000000p 0 20000000p
set filetype=ascii
write tran.raw
.endc
.end

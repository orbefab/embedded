* v-steps: generated by packages/engine/scripts/ngspice_refs.py from netlist.json. Do not edit.
.options temp=25 tnom=25 reltol=1e-9 abstol=1e-15 vntol=1e-12 gmin=1e-12
cc1 vout 0 5e-09
rr1 vin vout 1000.0
vv1 vin 0 dc 0.0 pwl(0p 0.0 99500p 0.0 100500p 5.0 9999500p 5.0 10000500p 1.0)
* One source per ramp corner makes it a breakpoint. ngspice skips a PWL corner it lands on an ulp early.
vbp0 bp0 0 pwl(99500p 0 99501p 0)
vbp1 bp1 0 pwl(100500p 0 100501p 0)
vbp2 bp2 0 pwl(9999500p 0 9999501p 0)
vbp3 bp3 0 pwl(10000500p 0 10000501p 0)
.control
save v(vin) v(vout) i(vv1) @cc1[i] @rr1[i]
tran 20000p 20000000p 0 20000p
set filetype=ascii
write tran.raw
.endc
.end

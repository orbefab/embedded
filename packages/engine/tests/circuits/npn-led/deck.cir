* npn-led: generated by packages/engine/scripts/ngspice_refs.py from netlist.json. Do not edit.
.options temp=25 tnom=25 reltol=1e-9 abstol=1e-15 vntol=1e-12 gmin=1e-12
dled1 vled c dmod_led1
.model dmod_led1 d (is=6.711e-10 n=4.427 rs=2.115)
vx_q1_c c x_q1_c dc 0
vx_q1_b b x_q1_b dc 0
qq1 x_q1_c x_q1_b 0 qmod_q1
.model qmod_q1 npn (is=8.095e-15 bf=173.2 br=0.2704 nf=1.0 nr=1.0 vaf=100.0 rb=5.707 rc=1.531 re=0.867 cje=8e-12 cjc=4e-12 mje=0 mjc=0)
rr1 vcc vled 220.0
rrb pin b 1000.0
vv1 vcc 0 dc 5.0
vvpin pin 0 dc 5.0
* The engine's gmin on every node, beside the gmin ngspice puts across each junction.
rx_gmin_b b 0 1000000000000.0
rx_gmin_c c 0 1000000000000.0
rx_gmin_pin pin 0 1000000000000.0
rx_gmin_vcc vcc 0 1000000000000.0
rx_gmin_vled vled 0 1000000000000.0
.control
save all @dled1[id] i(vx_q1_c) i(vx_q1_b) @rr1[i] @rrb[i]
op
set filetype=ascii
write op.raw all
.endc
.end

* zener-shunt: generated by packages/engine/scripts/ngspice_refs.py from netlist.json. Do not edit.
.options temp=25 tnom=25 reltol=1e-9 abstol=1e-15 vntol=1e-12 gmin=1e-12
rx_dz1_s 0 x_dz1 0.3512998076842114
dx_dz1_f x_dz1 vz dmodf_dz1
rx_dz1_b x_dz1_b vz 4.518344790967284
dx_dz1_b x_dz1_b x_dz1 dmodb_dz1
.model dmodf_dz1 d (is=2.908000103814407e-13 n=1.2314970051462708)
.model dmodb_dz1 d (is=2.9162818439975884e-22 n=4.062940282254739)
rr1 vin vz 100.0
rrload vz 0 1000.0
vv1 vin 0 dc 9.0
* The engine's gmin on every node, beside the gmin ngspice puts across each junction.
rx_gmin_vin vin 0 1000000000000.0
rx_gmin_vz vz 0 1000000000000.0
.control
save all @rx_dz1_s[i] @rr1[i] @rrload[i]
op
set filetype=ascii
write op.raw all
.endc
.end

* rc-picofarad: generated by packages/engine/scripts/ngspice_refs.py from netlist.json. Do not edit.
.options temp=25 tnom=25 reltol=1e-9 abstol=1e-15 vntol=1e-12 gmin=1e-12
cc1 top 0 1e-12
ii1 0 rail dc 0.0 pwl(0p 0.0 1000000000p 0.0 1000001000p 0.0005)
rr1 rail top 1.0
rrs vbus rail 0.2
vv1 vbus 0 dc 5.0
* One source per ramp corner makes it a breakpoint. ngspice skips a PWL corner it lands on an ulp early.
vbp0 bp0 0 pwl(1000000000p 0 1000000001p 0)
vbp1 bp1 0 pwl(1000001000p 0 1000001001p 0)
.control
save v(vbus) v(rail) v(top) i(vv1) @cc1[i] @ii1[current] @rr1[i] @rrs[i]
tran 5000000p 5000000000p 0 5000000p
set filetype=ascii
write tran.raw
.endc
.end

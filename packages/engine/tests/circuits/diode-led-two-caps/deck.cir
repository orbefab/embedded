* diode-led-two-caps: generated by packages/engine/scripts/ngspice_refs.py from netlist.json. Do not edit.
.options temp=25 tnom=25 reltol=1e-9 abstol=1e-15 vntol=1e-12 gmin=1e-12
cc1 vcc 0 1e-07
cc2 vcc 0 0.0001
dd1 va vd dmod_d1
.model dmod_d1 d (is=9.4334e-08 n=2.0844 rs=0.0317)
dled1 vled 0 dmod_led1
.model dmod_led1 d (is=6.711e-10 n=4.427 rs=2.115)
rr1 vd vled 220.0
rrs vin vcc 0.21
ssw1 vcc va ctl_sw1 0 swmod_sw1
.model swmod_sw1 sw (vt=0.5 vh=0 ron=0.1 roff=1000000000.0)
vctl_sw1 ctl_sw1 0 pwl(0p 0 100000000p 0 100001000p 1 500000000000p 1 500000001000p 0)
vv1 vin 0 dc 5.0
* The engine's gmin on every node, beside the gmin ngspice puts across each junction.
rx_gmin_vin vin 0 1000000000000.0
rx_gmin_vcc vcc 0 1000000000000.0
rx_gmin_va va 0 1000000000000.0
rx_gmin_vd vd 0 1000000000000.0
rx_gmin_vled vled 0 1000000000000.0
* One source per ramp corner makes it a breakpoint. ngspice skips a PWL corner it lands on an ulp early.
vbp0 bp0 0 pwl(100000000p 0 100000001p 0)
vbp1 bp1 0 pwl(100001000p 0 100001001p 0)
vbp2 bp2 0 pwl(500000000000p 0 500000000001p 0)
vbp3 bp3 0 pwl(500000001000p 0 500000001001p 0)
.control
save v(vin) v(vcc) v(va) v(vd) v(vled) i(vv1) @cc1[i] @cc2[i] @dd1[id] @dled1[id] @rr1[i] @rrs[i] @ssw1[i]
tran 1000000000p 1000000000000p 0 1000000000p
set filetype=ascii
write tran.raw
.endc
.end

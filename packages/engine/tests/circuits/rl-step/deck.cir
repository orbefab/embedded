* rl-step: generated by packages/engine/scripts/ngspice_refs.py from netlist.json. Do not edit.
.options temp=25 tnom=25 reltol=1e-5 abstol=1e-15 vntol=1e-12 gmin=1e-12
rx_l1_s vin x_l1 70.0
ll1 x_l1 0 0.505
vv1 vin 0 dc 0.0 pwl(0p 0.0 1000000000p 0.0 1000001000p 5.0 30000000000p 5.0 30000001000p 0.0)
* One source per corner. Its first point is the corner, a breakpoint from t = 0, and its second point is the stop.
vbp0 bp0 0 pwl(1000000000p 0 50000000000p 0)
vbp1 bp1 0 pwl(1000001000p 0 50000000000p 0)
vbp2 bp2 0 pwl(30000000000p 0 50000000000p 0)
vbp3 bp3 0 pwl(30000001000p 0 50000000000p 0)
.control
save v(vin) i(vv1) i(ll1)
tran 50000000p 50000000000p 0 833333p
set filetype=ascii
write tran.raw
.endc
.end

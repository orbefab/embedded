* divider: generated by packages/engine/scripts/ngspice_refs.py from netlist.json. Do not edit.
.options temp=25 tnom=25 reltol=1e-9 abstol=1e-15 vntol=1e-12 gmin=1e-12
rr1 vin vout 1000.0
rr2 vout 0 2000.0
vv1 vin 0 dc 5.0
.control
save all @rr1[i] @rr2[i]
op
set filetype=ascii
write op.raw all
.endc
.end

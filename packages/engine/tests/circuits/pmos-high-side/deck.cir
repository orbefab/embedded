* pmos-high-side: generated by packages/engine/scripts/ngspice_refs.py from netlist.json. Do not edit.
.options temp=25 tnom=25 reltol=1e-9 abstol=1e-15 vntol=1e-12 gmin=1e-12
vx_m1_d d x_m1_d dc 0
vx_m1_g g x_m1_g dc 0
mm1 x_m1_d x_m1_g src src mmod_m1 l=100u w=100u
.model mmod_m1 pmos (level=1 vto=-0.8 kp=4.579 lambda=0.0 is=0)
cm1_gs x_m1_g src 7.23e-10
cm1_gd x_m1_g x_m1_d 5.6e-11
cm1_ds x_m1_d src 6.5e-11
rrg pin g 100.0
rrl d 0 10.0
vvpin pin 0 dc 5.0 pwl(0p 5.0 1000000000p 5.0 1000001000p 0.0 3000000000p 0.0 3000001000p 5.0)
vvsrc src 0 dc 5.0
* The engine's gmin on every node, beside the gmin ngspice puts across each junction.
rx_gmin_d d 0 1000000000000.0
rx_gmin_g g 0 1000000000000.0
rx_gmin_pin pin 0 1000000000000.0
rx_gmin_src src 0 1000000000000.0
* One source per ramp corner makes it a breakpoint. ngspice skips a PWL corner it lands on an ulp early.
vbp0 bp0 0 pwl(1000000000p 0 1000000001p 0)
vbp1 bp1 0 pwl(1000001000p 0 1000001001p 0)
vbp2 bp2 0 pwl(3000000000p 0 3000000001p 0)
vbp3 bp3 0 pwl(3000001000p 0 3000001001p 0)
.control
save v(d) v(g) v(pin) v(src) i(vvpin) i(vvsrc) i(vx_m1_d) i(vx_m1_g) @rrg[i] @rrl[i]
tran 5000000p 5000000000p 0 5000000p
set filetype=ascii
write tran.raw
.endc
.end

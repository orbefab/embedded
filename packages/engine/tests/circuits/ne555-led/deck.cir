* ne555-led: generated by packages/engine/scripts/ngspice_refs.py from netlist.json. Do not edit.
.options temp=25 tnom=25 reltol=1e-9 abstol=1e-15 vntol=1e-12 gmin=1e-12
cc1 thr 0 1e-05
.ic v(thr)=0.0
cccont cont 0 1e-08
dled1 vled 0 dmod_led1
.model dmod_led1 d (is=6.711e-10 n=4.427 rs=2.115)
rra vcc dis 10000.0
rrb dis thr 47000.0
rrled out vled 220.0
rx_u1_l1 vcc cont 5000.0
rx_u1_l2 cont x_u1_lo 5000.0
rx_u1_l3 x_u1_lo 0 5000.0
rx_u1_sup vcc 0 1875.0
* u1 latch: RESET overrides TRIG, TRIG overrides THRES (SLFS022K Table 6-1).
bx_u1_s x_u1_s 0 v = (V(vcc,0) > 0.7) ? ((V(thr,x_u1_lo) > 0) ? ((V(thr,cont) > 0) ? 0 : (V(x_u1_q) > 0.5 ? 1 : 0)) : 1) : 0
rx_u1_q x_u1_s x_u1_q 1
cx_u1_q x_u1_q 0 1e-12
bx_u1_oh vcc out i = (V(x_u1_q) > 0.5) ? (V(vcc,out) - 0.9) / 8.0 : 0
bx_u1_ol out 0 i = (V(x_u1_q) > 0.5) ? 0 : (V(out,0) - 0.016666666666666666) / 16.666666666666668
bx_u1_d dis 0 i = V(dis,0) / ((V(x_u1_q) > 0.5) ? 250000000.0 : 18.75)
vv1 vcc 0 dc 5.0
* The engine's gmin on every node. A chip's ladder holds CONT flat, with no span to hide it.
rx_gmin_vcc vcc 0 1000000000000.0
rx_gmin_dis dis 0 1000000000000.0
rx_gmin_thr thr 0 1000000000000.0
rx_gmin_cont cont 0 1000000000000.0
rx_gmin_out out 0 1000000000000.0
rx_gmin_vled vled 0 1000000000000.0
rx_gmin_x_u1_lo x_u1_lo 0 1000000000000.0
.control
save v(vcc) v(dis) v(thr) v(cont) v(out) v(vled) i(vv1) @cc1[i] @cccont[i] @dled1[id] @rra[i] @rrb[i] @rrled[i] v(x_u1_q)
tran 2000000000p 4000000000000p 0 10000000p
set filetype=ascii
write edges.raw v(x_u1_q)
linearize v(vcc) v(dis) v(thr) v(cont) v(out) v(vled) i(vv1) @cc1[i] @cccont[i] @dled1[id] @rra[i] @rrb[i] @rrled[i]
write tran.raw
.endc
.end

* regulator-dropout: generated by packages/engine/scripts/ngspice_refs.py from netlist.json. Do not edit.
.options temp=25 tnom=25 reltol=1e-9 abstol=1e-15 vntol=1e-12 gmin=1e-12
.func sp(x) {ln(1+exp(-abs(x))) + (x>0 ? x : 0)}
.func smin(a,b) {a - 1e-3*sp((a-b)/1e-3)}
.func h(x) {x<=0 ? 0 : (x>=1 ? 1 : x*x*(3-2*x))}
rrl vout 0 33.0
bx_u1_v x_u1 0 v = smin((3.3+9.75609756097561e-05*(v(vin,0)-3.3)-0.00125*i(vx_u1)), (-0.25*i(vx_u1)+1e-3*sp(((v(vin,0)-1.0857142857142859-0.14285714285714288*i(vx_u1))+0.25*i(vx_u1))/1e-3))) - 275.0*0.0012*sp((i(vx_u1)-1.2)/0.0012) + 1000000000.0*1e-12*sp(-i(vx_u1)/1e-12)
vx_u1 x_u1 vout dc 0
fx_u1 vin 0 vx_u1 1
bx_u1_g x_u1_g 0 i = (0.005+0.0*i(vx_u1))*h(v(vin,0)/1.0857142857142859)+0.005*(v(vin,0))/1.0857142857142859*h(-(v(vin,0))/1.0857142857142859)
vx_u1_g vin x_u1_g dc 0
vv1 vin 0 dc 0.0 pwl(0p 0.0 1000000000p 0.0 1000001000p 0.1 2000000000p 0.1 2000001000p 0.2 3000000000p 0.2 3000001000p 0.3 4000000000p 0.3 4000001000p 0.4 5000000000p 0.4 5000001000p 0.5 6000000000p 0.5 6000001000p 0.6 7000000000p 0.6 7000001000p 0.7 8000000000p 0.7 8000001000p 0.8 9000000000p 0.8 9000001000p 0.9 10000000000p 0.9 10000001000p 1.0 11000000000p 1.0 11000001000p 1.1 12000000000p 1.1 12000001000p 1.2 13000000000p 1.2 13000001000p 1.3 14000000000p 1.3 14000001000p 1.4 15000000000p 1.4 15000001000p 1.5 16000000000p 1.5 16000001000p 1.6 17000000000p 1.6 17000001000p 1.7 18000000000p 1.7 18000001000p 1.8 19000000000p 1.8 19000001000p 1.9 20000000000p 1.9 20000001000p 2.0 21000000000p 2.0 21000001000p 2.1 22000000000p 2.1 22000001000p 2.2 23000000000p 2.2 23000001000p 2.3 24000000000p 2.3 24000001000p 2.4 25000000000p 2.4 25000001000p 2.5 26000000000p 2.5 26000001000p 2.6 27000000000p 2.6 27000001000p 2.7 28000000000p 2.7 28000001000p 2.8 29000000000p 2.8 29000001000p 2.9 30000000000p 2.9 30000001000p 3.0 31000000000p 3.0 31000001000p 3.1 32000000000p 3.1 32000001000p 3.2 33000000000p 3.2 33000001000p 3.3 34000000000p 3.3 34000001000p 3.4 35000000000p 3.4 35000001000p 3.5 36000000000p 3.5 36000001000p 3.6 37000000000p 3.6 37000001000p 3.7 38000000000p 3.7 38000001000p 3.8 39000000000p 3.8 39000001000p 3.9 40000000000p 3.9 40000001000p 4.0 41000000000p 4.0 41000001000p 4.1 42000000000p 4.1 42000001000p 4.2 43000000000p 4.2 43000001000p 4.3 44000000000p 4.3 44000001000p 4.4 45000000000p 4.4 45000001000p 4.5 46000000000p 4.5 46000001000p 4.6 47000000000p 4.6 47000001000p 4.7 48000000000p 4.7 48000001000p 4.8 49000000000p 4.8 49000001000p 4.9 50000000000p 4.9 50000001000p 5.0 51000000000p 5.0 51000001000p 5.1 52000000000p 5.1 52000001000p 5.2 53000000000p 5.2 53000001000p 5.3 54000000000p 5.3 54000001000p 5.4 55000000000p 5.4 55000001000p 5.5 56000000000p 5.5 56000001000p 5.6 57000000000p 5.6 57000001000p 5.7 58000000000p 5.7 58000001000p 5.8 59000000000p 5.8 59000001000p 5.9 60000000000p 5.9)
* The engine's gmin on every external node. The regulator's internal nodes are not shunted.
rx_gmin_vin vin 0 1000000000000.0
rx_gmin_vout vout 0 1000000000000.0
* One source per ramp corner makes it a breakpoint. ngspice skips a PWL corner it lands on an ulp early.
vbp0 bp0 0 pwl(1000000000p 0 1000000001p 0)
vbp1 bp1 0 pwl(1000001000p 0 1000001001p 0)
vbp2 bp2 0 pwl(2000000000p 0 2000000001p 0)
vbp3 bp3 0 pwl(2000001000p 0 2000001001p 0)
vbp4 bp4 0 pwl(3000000000p 0 3000000001p 0)
vbp5 bp5 0 pwl(3000001000p 0 3000001001p 0)
vbp6 bp6 0 pwl(4000000000p 0 4000000001p 0)
vbp7 bp7 0 pwl(4000001000p 0 4000001001p 0)
vbp8 bp8 0 pwl(5000000000p 0 5000000001p 0)
vbp9 bp9 0 pwl(5000001000p 0 5000001001p 0)
vbp10 bp10 0 pwl(6000000000p 0 6000000001p 0)
vbp11 bp11 0 pwl(6000001000p 0 6000001001p 0)
vbp12 bp12 0 pwl(7000000000p 0 7000000001p 0)
vbp13 bp13 0 pwl(7000001000p 0 7000001001p 0)
vbp14 bp14 0 pwl(8000000000p 0 8000000001p 0)
vbp15 bp15 0 pwl(8000001000p 0 8000001001p 0)
vbp16 bp16 0 pwl(9000000000p 0 9000000001p 0)
vbp17 bp17 0 pwl(9000001000p 0 9000001001p 0)
vbp18 bp18 0 pwl(10000000000p 0 10000000001p 0)
vbp19 bp19 0 pwl(10000001000p 0 10000001001p 0)
vbp20 bp20 0 pwl(11000000000p 0 11000000001p 0)
vbp21 bp21 0 pwl(11000001000p 0 11000001001p 0)
vbp22 bp22 0 pwl(12000000000p 0 12000000001p 0)
vbp23 bp23 0 pwl(12000001000p 0 12000001001p 0)
vbp24 bp24 0 pwl(13000000000p 0 13000000001p 0)
vbp25 bp25 0 pwl(13000001000p 0 13000001001p 0)
vbp26 bp26 0 pwl(14000000000p 0 14000000001p 0)
vbp27 bp27 0 pwl(14000001000p 0 14000001001p 0)
vbp28 bp28 0 pwl(15000000000p 0 15000000001p 0)
vbp29 bp29 0 pwl(15000001000p 0 15000001001p 0)
vbp30 bp30 0 pwl(16000000000p 0 16000000001p 0)
vbp31 bp31 0 pwl(16000001000p 0 16000001001p 0)
vbp32 bp32 0 pwl(17000000000p 0 17000000001p 0)
vbp33 bp33 0 pwl(17000001000p 0 17000001001p 0)
vbp34 bp34 0 pwl(18000000000p 0 18000000001p 0)
vbp35 bp35 0 pwl(18000001000p 0 18000001001p 0)
vbp36 bp36 0 pwl(19000000000p 0 19000000001p 0)
vbp37 bp37 0 pwl(19000001000p 0 19000001001p 0)
vbp38 bp38 0 pwl(20000000000p 0 20000000001p 0)
vbp39 bp39 0 pwl(20000001000p 0 20000001001p 0)
vbp40 bp40 0 pwl(21000000000p 0 21000000001p 0)
vbp41 bp41 0 pwl(21000001000p 0 21000001001p 0)
vbp42 bp42 0 pwl(22000000000p 0 22000000001p 0)
vbp43 bp43 0 pwl(22000001000p 0 22000001001p 0)
vbp44 bp44 0 pwl(23000000000p 0 23000000001p 0)
vbp45 bp45 0 pwl(23000001000p 0 23000001001p 0)
vbp46 bp46 0 pwl(24000000000p 0 24000000001p 0)
vbp47 bp47 0 pwl(24000001000p 0 24000001001p 0)
vbp48 bp48 0 pwl(25000000000p 0 25000000001p 0)
vbp49 bp49 0 pwl(25000001000p 0 25000001001p 0)
vbp50 bp50 0 pwl(26000000000p 0 26000000001p 0)
vbp51 bp51 0 pwl(26000001000p 0 26000001001p 0)
vbp52 bp52 0 pwl(27000000000p 0 27000000001p 0)
vbp53 bp53 0 pwl(27000001000p 0 27000001001p 0)
vbp54 bp54 0 pwl(28000000000p 0 28000000001p 0)
vbp55 bp55 0 pwl(28000001000p 0 28000001001p 0)
vbp56 bp56 0 pwl(29000000000p 0 29000000001p 0)
vbp57 bp57 0 pwl(29000001000p 0 29000001001p 0)
vbp58 bp58 0 pwl(30000000000p 0 30000000001p 0)
vbp59 bp59 0 pwl(30000001000p 0 30000001001p 0)
vbp60 bp60 0 pwl(31000000000p 0 31000000001p 0)
vbp61 bp61 0 pwl(31000001000p 0 31000001001p 0)
vbp62 bp62 0 pwl(32000000000p 0 32000000001p 0)
vbp63 bp63 0 pwl(32000001000p 0 32000001001p 0)
vbp64 bp64 0 pwl(33000000000p 0 33000000001p 0)
vbp65 bp65 0 pwl(33000001000p 0 33000001001p 0)
vbp66 bp66 0 pwl(34000000000p 0 34000000001p 0)
vbp67 bp67 0 pwl(34000001000p 0 34000001001p 0)
vbp68 bp68 0 pwl(35000000000p 0 35000000001p 0)
vbp69 bp69 0 pwl(35000001000p 0 35000001001p 0)
vbp70 bp70 0 pwl(36000000000p 0 36000000001p 0)
vbp71 bp71 0 pwl(36000001000p 0 36000001001p 0)
vbp72 bp72 0 pwl(37000000000p 0 37000000001p 0)
vbp73 bp73 0 pwl(37000001000p 0 37000001001p 0)
vbp74 bp74 0 pwl(38000000000p 0 38000000001p 0)
vbp75 bp75 0 pwl(38000001000p 0 38000001001p 0)
vbp76 bp76 0 pwl(39000000000p 0 39000000001p 0)
vbp77 bp77 0 pwl(39000001000p 0 39000001001p 0)
vbp78 bp78 0 pwl(40000000000p 0 40000000001p 0)
vbp79 bp79 0 pwl(40000001000p 0 40000001001p 0)
vbp80 bp80 0 pwl(41000000000p 0 41000000001p 0)
vbp81 bp81 0 pwl(41000001000p 0 41000001001p 0)
vbp82 bp82 0 pwl(42000000000p 0 42000000001p 0)
vbp83 bp83 0 pwl(42000001000p 0 42000001001p 0)
vbp84 bp84 0 pwl(43000000000p 0 43000000001p 0)
vbp85 bp85 0 pwl(43000001000p 0 43000001001p 0)
vbp86 bp86 0 pwl(44000000000p 0 44000000001p 0)
vbp87 bp87 0 pwl(44000001000p 0 44000001001p 0)
vbp88 bp88 0 pwl(45000000000p 0 45000000001p 0)
vbp89 bp89 0 pwl(45000001000p 0 45000001001p 0)
vbp90 bp90 0 pwl(46000000000p 0 46000000001p 0)
vbp91 bp91 0 pwl(46000001000p 0 46000001001p 0)
vbp92 bp92 0 pwl(47000000000p 0 47000000001p 0)
vbp93 bp93 0 pwl(47000001000p 0 47000001001p 0)
vbp94 bp94 0 pwl(48000000000p 0 48000000001p 0)
vbp95 bp95 0 pwl(48000001000p 0 48000001001p 0)
vbp96 bp96 0 pwl(49000000000p 0 49000000001p 0)
vbp97 bp97 0 pwl(49000001000p 0 49000001001p 0)
vbp98 bp98 0 pwl(50000000000p 0 50000000001p 0)
vbp99 bp99 0 pwl(50000001000p 0 50000001001p 0)
vbp100 bp100 0 pwl(51000000000p 0 51000000001p 0)
vbp101 bp101 0 pwl(51000001000p 0 51000001001p 0)
vbp102 bp102 0 pwl(52000000000p 0 52000000001p 0)
vbp103 bp103 0 pwl(52000001000p 0 52000001001p 0)
vbp104 bp104 0 pwl(53000000000p 0 53000000001p 0)
vbp105 bp105 0 pwl(53000001000p 0 53000001001p 0)
vbp106 bp106 0 pwl(54000000000p 0 54000000001p 0)
vbp107 bp107 0 pwl(54000001000p 0 54000001001p 0)
vbp108 bp108 0 pwl(55000000000p 0 55000000001p 0)
vbp109 bp109 0 pwl(55000001000p 0 55000001001p 0)
vbp110 bp110 0 pwl(56000000000p 0 56000000001p 0)
vbp111 bp111 0 pwl(56000001000p 0 56000001001p 0)
vbp112 bp112 0 pwl(57000000000p 0 57000000001p 0)
vbp113 bp113 0 pwl(57000001000p 0 57000001001p 0)
vbp114 bp114 0 pwl(58000000000p 0 58000000001p 0)
vbp115 bp115 0 pwl(58000001000p 0 58000001001p 0)
vbp116 bp116 0 pwl(59000000000p 0 59000000001p 0)
vbp117 bp117 0 pwl(59000001000p 0 59000001001p 0)
vbp118 bp118 0 pwl(60000000000p 0 60000000001p 0)
.control
save v(vin) v(vout) i(vv1) @rrl[i] i(vx_u1) i(vx_u1_g)
tran 60000000p 60000000000p 0 60000000p
set filetype=ascii
write tran.raw
.endc
.end

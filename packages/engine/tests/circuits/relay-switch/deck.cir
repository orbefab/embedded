* relay-switch: generated by packages/engine/scripts/ngspice_refs.py from netlist.json. Do not edit.
.options temp=25 tnom=25 reltol=1e-5 abstol=1e-15 vntol=1e-12 gmin=1e-12
dd1 coil vcc dmod_d1
.model dmod_d1 d (is=9.4334e-08 n=2.0844 rs=0.0317)
rx_k1_s vcc x_k1 70.0
lk1 x_k1 x_k1_c 0.505
vx_k1_am x_k1_c coil dc 0
bx_k1_m x_k1_m 0 v = abs(i(vx_k1_am))
sx_k1_no vcc no x_k1_m 0 swno_k1
.model swno_k1 sw (vt=0.030357142857142857 vh=0.02321428571428571 ron=0.1 roff=100000000.0)
sx_k1_nc vcc nc x_k1_m 0 swnc_k1
.model swnc_k1 sw (vt=0.030357142857142857 vh=0.02321428571428571 ron=100000000.0 roff=0.1)
dled1 vled 0 dmod_led1
.model dmod_led1 d (is=6.711e-10 n=4.427 rs=2.115)
rrl no vled 220.0
rrnc nc 0 1000.0
ss1 coil 0 ctl_s1 0 swmod_s1
.model swmod_s1 sw (vt=0.5 vh=0 ron=0.1 roff=1000000.0)
vctl_s1 ctl_s1 0 pwl(0p 0 2000000000p 0 2000001000p 1 30000000000p 1 30000001000p 0)
vv1 vcc 0 dc 5.0
* The engine's gmin on every node, beside the gmin ngspice puts across each junction.
rx_gmin_vcc vcc 0 1000000000000.0
rx_gmin_coil coil 0 1000000000000.0
rx_gmin_no no 0 1000000000000.0
rx_gmin_nc nc 0 1000000000000.0
rx_gmin_vled vled 0 1000000000000.0
* One source per corner. Its first point is the corner, a breakpoint from t = 0, and its second point is the stop.
vbp0 bp0 0 pwl(2000000000p 0 60000000000p 0)
vbp1 bp1 0 pwl(2000001000p 0 60000000000p 0)
vbp2 bp2 0 pwl(30000000000p 0 60000000000p 0)
vbp3 bp3 0 pwl(30000001000p 0 60000000000p 0)
.control
save v(vcc) v(coil) v(no) v(nc) v(vled) i(vv1) @dd1[id] i(vx_k1_am) @dled1[id] @rrl[i] @rrnc[i] @ss1[i]
tran 60000000p 60000000000p 0 1000000p
set filetype=ascii
write tran.raw
.endc
.end

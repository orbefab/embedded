* inductor-open-end: generated by packages/engine/scripts/ngspice_refs.py from netlist.json. Do not edit.
.options temp=25 tnom=25 reltol=1e-5 abstol=1e-15 vntol=1e-12 gmin=1e-12
rx_l1_s v5 x_l1 0.5
ll1 x_l1 avcc 1e-05
dled1 vled 0 dmod_led1
.model dmod_led1 d (is=6.711e-10 n=4.427 rs=2.115)
rr1 sw vled 150.0
rrs vbus v5 0.21
ss1 v5 sw ctl_s1 0 swmod_s1
.model swmod_s1 sw (vt=0.5 vh=0 ron=0.1 roff=1000000000.0)
vctl_s1 ctl_s1 0 pwl(0p 0 1000000000p 0 1000001000p 1 3000000000p 1 3000001000p 0)
vv1 vbus 0 dc 5.0
* The engine's gmin on every node, beside the gmin ngspice puts across each junction.
rx_gmin_vbus vbus 0 1000000000000.0
rx_gmin_v5 v5 0 1000000000000.0
rx_gmin_avcc avcc 0 1000000000000.0
rx_gmin_sw sw 0 1000000000000.0
rx_gmin_vled vled 0 1000000000000.0
* One source per corner. Its first point is the corner, a breakpoint from t = 0, and its second point is the stop.
vbp0 bp0 0 pwl(1000000000p 0 5000000000p 0)
vbp1 bp1 0 pwl(1000001000p 0 5000000000p 0)
vbp2 bp2 0 pwl(3000000000p 0 5000000000p 0)
vbp3 bp3 0 pwl(3000001000p 0 5000000000p 0)
.control
save v(vbus) v(v5) v(avcc) v(sw) v(vled) i(vv1) i(ll1) @dled1[id] @rr1[i] @rrs[i] @ss1[i]
tran 5000000p 5000000000p 0 83333p
set filetype=ascii
write tran.raw
.endc
.end

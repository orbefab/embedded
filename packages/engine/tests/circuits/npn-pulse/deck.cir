* npn-pulse: generated by packages/engine/scripts/ngspice_refs.py from netlist.json. Do not edit.
.options temp=25 tnom=25 reltol=1e-9 abstol=1e-15 vntol=1e-12 gmin=1e-12
ccl c 0 1e-07
vx_q1_c c x_q1_c dc 0
vx_q1_b b x_q1_b dc 0
qq1 x_q1_c x_q1_b 0 qmod_q1
.model qmod_q1 npn (is=8.095e-15 bf=173.2 br=0.2704 nf=1.0 nr=1.0 vaf=100.0 rb=5.707 rc=1.531 re=0.867 cje=8e-12 cjc=4e-12 mje=0 mjc=0)
rrb pin b 10000.0
rrl vcc c 1000.0
vv1 vcc 0 dc 5.0
vvpin pin 0 dc 0.0 pwl(0p 0.0 200000000p 0.0 200001000p 5.0 700000000p 5.0 700001000p 0.0 1200000000p 0.0)
* The engine's gmin on every node, beside the gmin ngspice puts across each junction.
rx_gmin_b b 0 1000000000000.0
rx_gmin_c c 0 1000000000000.0
rx_gmin_pin pin 0 1000000000000.0
rx_gmin_vcc vcc 0 1000000000000.0
* One source per ramp corner makes it a breakpoint. ngspice skips a PWL corner it lands on an ulp early.
vbp0 bp0 0 pwl(200000000p 0 200000001p 0)
vbp1 bp1 0 pwl(200001000p 0 200001001p 0)
vbp2 bp2 0 pwl(700000000p 0 700000001p 0)
vbp3 bp3 0 pwl(700001000p 0 700001001p 0)
.control
save v(b) v(c) v(pin) v(vcc) i(vv1) i(vvpin) @ccl[i] i(vx_q1_c) i(vx_q1_b) @rrb[i] @rrl[i]
tran 1100000p 1100000000p 0 1100000p
set filetype=ascii
write tran.raw
.endc
.end

* i-divider: generated by packages/engine/scripts/ngspice_refs.py from netlist.json. Do not edit.
.options temp=25 tnom=25 reltol=1e-9 abstol=1e-15 vntol=1e-12 gmin=1e-12
ii1 0 vt dc 0.001
rr1 vt 0 1000.0
rr2 vt 0 2000.0
.control
save all @ii1[current] @rr1[i] @rr2[i]
op
set filetype=ascii
write op.raw all
.endc
.end

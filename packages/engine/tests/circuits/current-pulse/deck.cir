* current-pulse: generated by packages/engine/scripts/ngspice_refs.py from netlist.json. Do not edit.
.options temp=25 tnom=25 reltol=1e-9 abstol=1e-15 vntol=1e-12 gmin=1e-12
cc1 vout 0 1e-06
ii1 0 vout dc 0.0002 pwl(0p 0.0002 1000000000p 0.0002 1000001000p 0.001 3000000000p 0.001 3000001000p 0.0002 6000000000p 0.0002 6000001000p 0.001 8000000000p 0.001 8000001000p 0.0002 11000000000p 0.0002 11000001000p 0.001 13000000000p 0.001 13000001000p 0.0002 16000000000p 0.0002)
rr1 vout 0 1000.0
* One source per ramp corner makes it a breakpoint. ngspice skips a PWL corner it lands on an ulp early.
vbp0 bp0 0 pwl(1000000000p 0 1000000001p 0)
vbp1 bp1 0 pwl(1000001000p 0 1000001001p 0)
vbp2 bp2 0 pwl(3000000000p 0 3000000001p 0)
vbp3 bp3 0 pwl(3000001000p 0 3000001001p 0)
vbp4 bp4 0 pwl(6000000000p 0 6000000001p 0)
vbp5 bp5 0 pwl(6000001000p 0 6000001001p 0)
vbp6 bp6 0 pwl(8000000000p 0 8000000001p 0)
vbp7 bp7 0 pwl(8000001000p 0 8000001001p 0)
vbp8 bp8 0 pwl(11000000000p 0 11000000001p 0)
vbp9 bp9 0 pwl(11000001000p 0 11000001001p 0)
vbp10 bp10 0 pwl(13000000000p 0 13000000001p 0)
vbp11 bp11 0 pwl(13000001000p 0 13000001001p 0)
vbp12 bp12 0 pwl(16000000000p 0 16000000001p 0)
.control
save v(vout) @cc1[i] @ii1[current] @rr1[i]
tran 16000000p 16000000000p 0 16000000p
set filetype=ascii
write tran.raw
.endc
.end

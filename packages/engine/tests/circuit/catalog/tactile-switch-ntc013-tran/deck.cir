* tactile-switch-ntc013-tran: generated by packages/engine/scripts/ngspice_refs.py from netlist.json. Do not edit.
.options temp=25 tnom=25 reltol=1e-9 abstol=1e-15 vntol=1e-12 gmin=1e-12
rrl out 0 1000.0
ssw1 vcc out ctl_sw1 0 swmod_sw1
.model swmod_sw1 sw (vt=0.5 vh=0 ron=0.5 roff=100000000.0)
vctl_sw1 ctl_sw1 0 pwl(0p 0 1000000p 0 1001000p 1 5000000p 1 5001000p 0)
vv1 vcc 0 dc 5.0
* One source per ramp corner makes it a breakpoint. ngspice skips a PWL corner it lands on an ulp early.
vbp0 bp0 0 pwl(1000000p 0 1000001p 0)
vbp1 bp1 0 pwl(1001000p 0 1001001p 0)
vbp2 bp2 0 pwl(5000000p 0 5000001p 0)
vbp3 bp3 0 pwl(5001000p 0 5001001p 0)
.control
save v(vcc) v(out) i(vv1) @rrl[i] @ssw1[i]
tran 10000p 10000000p 0 10000p
set filetype=ascii
write tran.raw
.endc
.end

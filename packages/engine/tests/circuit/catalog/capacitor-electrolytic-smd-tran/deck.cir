* capacitor-electrolytic-smd-tran: generated by packages/engine/scripts/ngspice_refs.py from netlist.json. Do not edit.
.options temp=25 tnom=25 reltol=1e-9 abstol=1e-15 vntol=1e-12 gmin=1e-12
rx_c1_s vc x_c1 5.64379230822324
cc1 x_c1 0 4.7e-05
rr1 vin vc 1000.0
vv1 vin 0 dc 0.0 pwl(0p 0.0 23500000000p 0.0 23500001000p 5.0)
* One source per ramp corner makes it a breakpoint. ngspice skips a PWL corner it lands on an ulp early.
vbp0 bp0 0 pwl(23500000000p 0 23500000001p 0)
vbp1 bp1 0 pwl(23500001000p 0 23500001001p 0)
.control
save v(vin) v(vc) i(vv1) @cc1[i] @rr1[i]
tran 235000000p 235000000000p 0 235000000p
set filetype=ascii
write tran.raw
.endc
.end

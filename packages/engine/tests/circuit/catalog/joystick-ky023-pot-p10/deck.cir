* joystick-ky023-pot-p10: generated by packages/engine/scripts/ngspice_refs.py from netlist.json. Do not edit.
.options temp=25 tnom=25 reltol=1e-9 abstol=1e-15 vntol=1e-12 gmin=1e-12
rrl w 0 10000.0
rrv1_a vcc w 1000.0
rrv1_b w 0 9000.0
vv1 vcc 0 dc 5.0
.control
save all @rrl[i]
op
set filetype=ascii
write op.raw all
.endc
.end

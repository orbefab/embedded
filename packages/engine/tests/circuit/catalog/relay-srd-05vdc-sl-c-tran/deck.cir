* relay-srd-05vdc-sl-c-tran: generated by packages/engine/scripts/ngspice_refs.py from netlist.json. Do not edit.
.options temp=25 tnom=25 reltol=1e-5 abstol=1e-15 vntol=1e-12 gmin=1e-12
dd1 coil vcc dmod_d1
.model dmod_d1 d (is=9.4334e-08 n=2.0844 rs=0.0317)
rx_k1_s vcc x_k1 70.0
lk1 x_k1 x_k1_c 0.07
vx_k1_am x_k1_c coil dc 0
bx_k1_m x_k1_m 0 v = abs(i(vx_k1_am))
sx_k1_no vcc no x_k1_m 0 swno_k1
.model swno_k1 sw (vt=0.030357142857142857 vh=0.02321428571428571 ron=0.1 roff=100000000.0)
sx_k1_nc vcc nc x_k1_m 0 swnc_k1
.model swnc_k1 sw (vt=0.030357142857142857 vh=0.02321428571428571 ron=100000000.0 roff=0.1)
rrnc nc 0 2200.0
rrno no 0 1000.0
ssw1 coil 0 ctl_sw1 0 swmod_sw1
.model swmod_sw1 sw (vt=0.5 vh=0 ron=0.1 roff=100000000.0)
vctl_sw1 ctl_sw1 0 pwl(0p 0 1000000000p 0 1000001000p 1 7000000000p 1 7000001000p 0)
vvcc vcc 0 dc 5.0
* The engine's gmin on every node, beside the gmin ngspice puts across each junction.
rx_gmin_vcc vcc 0 1000000000000.0
rx_gmin_coil coil 0 1000000000000.0
rx_gmin_no no 0 1000000000000.0
rx_gmin_nc nc 0 1000000000000.0
* One source per corner. Its first point is the corner, a breakpoint from t = 0, and its second point is the stop.
vbp0 bp0 0 pwl(1000000000p 0 15000000000p 0)
vbp1 bp1 0 pwl(1000001000p 0 15000000000p 0)
vbp2 bp2 0 pwl(7000000000p 0 15000000000p 0)
vbp3 bp3 0 pwl(7000001000p 0 15000000000p 0)
.control
save v(vcc) v(coil) v(no) v(nc) i(vvcc) @dd1[id] i(vx_k1_am) @rrnc[i] @rrno[i] @ssw1[i]
tran 15000000p 15000000000p 0 250000p
set filetype=ascii
write tran.raw
.endc
.end

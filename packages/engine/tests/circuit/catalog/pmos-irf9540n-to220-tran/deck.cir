* pmos-irf9540n-to220-tran: generated by packages/engine/scripts/ngspice_refs.py from netlist.json. Do not edit.
.options temp=25 tnom=25 reltol=1e-9 abstol=1e-15 vntol=1e-12 gmin=1e-12
vx_m1_d d x_m1_d dc 0
vx_m1_g g x_m1_g dc 0
mm1 x_m1_d x_m1_g vdd vdd mmod_m1 l=100u w=100u
.model mmod_m1 pmos (level=1 vto=-3.0 kp=1.3446092263051281 lambda=0.0 is=0)
cm1_gs x_m1_g vdd 1.06e-09
cm1_gd x_m1_g x_m1_d 2.4e-10
cm1_ds x_m1_d vdd 1.6e-10
rrd d 0 100.0
rrg vg g 100000.0
vvdd vdd 0 dc 10.0
vvg vg 0 dc 10.0 pwl(0p 10.0 10000000p 10.0 10001000p 0.0 90000000p 0.0 90001000p 10.0 410000000p 10.0)
* The engine's gmin on every node, beside the gmin ngspice puts across each junction.
rx_gmin_vdd vdd 0 1000000000000.0
rx_gmin_vg vg 0 1000000000000.0
rx_gmin_g g 0 1000000000000.0
rx_gmin_d d 0 1000000000000.0
* One source per ramp corner makes it a breakpoint. ngspice skips a PWL corner it lands on an ulp early.
vbp0 bp0 0 pwl(10000000p 0 10000001p 0)
vbp1 bp1 0 pwl(10001000p 0 10001001p 0)
vbp2 bp2 0 pwl(90000000p 0 90000001p 0)
vbp3 bp3 0 pwl(90001000p 0 90001001p 0)
.control
save v(vdd) v(vg) v(g) v(d) i(vvdd) i(vvg) i(vx_m1_d) i(vx_m1_g) @rrd[i] @rrg[i]
tran 200000p 200000000p 0 200000p
set filetype=ascii
write tran.raw
.endc
.end

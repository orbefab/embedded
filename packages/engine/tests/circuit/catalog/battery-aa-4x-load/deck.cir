* battery-aa-4x-load: generated by packages/engine/scripts/ngspice_refs.py from netlist.json. Do not edit.
.options temp=25 tnom=25 reltol=1e-9 abstol=1e-15 vntol=1e-12 gmin=1e-12
vcell cell 0 dc 6.0
rr_int cell vout 0.9
rrl vout 0 100.0
.control
save all @rr_int[i] @rrl[i]
op
set filetype=ascii
write op.raw all
.endc
.end

* npn-2n2222-to92-active: generated by packages/engine/scripts/ngspice_refs.py from netlist.json. Do not edit.
.options temp=25 tnom=25 reltol=1e-9 abstol=1e-15 vntol=1e-12 gmin=1e-12
vx_q1_c c x_q1_c dc 0
vx_q1_b b x_q1_b dc 0
qq1 x_q1_c x_q1_b 0 qmod_q1
.model qmod_q1 npn (is=4.572e-14 bf=218.8 br=14.09 nf=1.0 nr=1.0 vaf=100.0 rb=3.909 rc=0.1523 re=0.3756 cje=2.5e-11 cjc=8e-12 ikf=0.57 mje=0 mjc=0)
rrb vin b 4700.0
rrc vcc c 22.0
vvcc vcc 0 dc 5.0
vvin vin 0 dc 5.0
* The engine's gmin on every node, beside the gmin ngspice puts across each junction.
rx_gmin_vcc vcc 0 1000000000000.0
rx_gmin_vin vin 0 1000000000000.0
rx_gmin_b b 0 1000000000000.0
rx_gmin_c c 0 1000000000000.0
.control
save all i(vx_q1_c) i(vx_q1_b) @rrb[i] @rrc[i]
op
set filetype=ascii
write op.raw all
.endc
.end

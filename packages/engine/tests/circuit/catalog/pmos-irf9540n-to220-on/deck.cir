* pmos-irf9540n-to220-on: generated by packages/engine/scripts/ngspice_refs.py from netlist.json. Do not edit.
.options temp=25 tnom=25 reltol=1e-9 abstol=1e-15 vntol=1e-12 gmin=1e-12
vx_m1_d d x_m1_d dc 0
vx_m1_g g x_m1_g dc 0
mm1 x_m1_d x_m1_g vdd vdd mmod_m1 l=100u w=100u
.model mmod_m1 pmos (level=1 vto=-3.0 kp=1.3446092263051281 lambda=0.0 is=0)
cm1_gs x_m1_g vdd 1.06e-09
cm1_gd x_m1_g x_m1_d 2.4e-10
cm1_ds x_m1_d vdd 1.6e-10
rrd d 0 100.0
rrg vg g 1000.0
vvdd vdd 0 dc 10.0
vvg vg 0 dc 5.5
* The engine's gmin on every node, beside the gmin ngspice puts across each junction.
rx_gmin_vdd vdd 0 1000000000000.0
rx_gmin_vg vg 0 1000000000000.0
rx_gmin_g g 0 1000000000000.0
rx_gmin_d d 0 1000000000000.0
.control
save all i(vx_m1_d) i(vx_m1_g) @rrd[i] @rrg[i]
op
set filetype=ascii
write op.raw all
.endc
.end

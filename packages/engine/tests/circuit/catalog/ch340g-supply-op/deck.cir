* ch340g-supply-op: generated by packages/engine/scripts/ngspice_refs.py from netlist.json. Do not edit.
.options temp=25 tnom=25 reltol=1e-9 abstol=1e-15 vntol=1e-12 gmin=1e-12
rr1 mid 0 416.67
rrsrc vin mid 100.0
vv1 vin 0 dc 5.0
.control
save all @rr1[i] @rrsrc[i]
op
set filetype=ascii
write op.raw all
.endc
.end

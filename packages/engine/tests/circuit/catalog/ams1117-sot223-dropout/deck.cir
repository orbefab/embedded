* ams1117-sot223-dropout: generated by packages/engine/scripts/ngspice_refs.py from netlist.json. Do not edit.
.options temp=25 tnom=25 reltol=1e-9 abstol=1e-15 vntol=1e-12 gmin=1e-12
.func sp(x) {ln(1+exp(-abs(x))) + (x>0 ? x : 0)}
.func smin(a,b) {a - 1e-3*sp((a-b)/1e-3)}
.func h(x) {x<=0 ? 0 : (x>=1 ? 1 : x*x*(3-2*x))}
rrl vout 0 15.152
bx_u1_v x_u1 0 v = smin((5.0+4.761904761904762e-05*(v(vin,0)-5.0)-0.00625*i(vx_u1)), (-0.25*i(vx_u1)+1e-3*sp(((v(vin,0)-1.0992-0.001*i(vx_u1))+0.25*i(vx_u1))/1e-3))) - 454.5454545454545*0.0011*sp((i(vx_u1)-1.1)/0.0011) + 1000000000.0*1e-12*sp(-i(vx_u1)/1e-12)
vx_u1 x_u1 vout dc 0
fx_u1 vin 0 vx_u1 1
bx_u1_g x_u1_g 0 i = (0.005+0.0*i(vx_u1))*h(v(vin,0)/1.0992)+0.005*(v(vin,0))/1.0992*h(-(v(vin,0))/1.0992)
vx_u1_g vin x_u1_g dc 0
vv1 vin 0 dc 4.7
* The engine's gmin on every external node. The regulator's internal nodes are not shunted.
rx_gmin_vin vin 0 1000000000000.0
rx_gmin_vout vout 0 1000000000000.0
.control
save all @rrl[i] i(vx_u1) i(vx_u1_g)
op
set filetype=ascii
write op.raw all
.endc
.end

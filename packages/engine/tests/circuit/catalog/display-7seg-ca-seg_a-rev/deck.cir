* display-7seg-ca-seg_a-rev: generated by packages/engine/scripts/ngspice_refs.py from netlist.json. Do not edit.
.options temp=25 tnom=25 reltol=1e-9 abstol=1e-15 vntol=1e-12 gmin=1e-12
dd1 va 0 dmod_d1
.model dmod_d1 d (is=3.272e-14 n=2.509 rs=9.532)
rr1 vin va 10000.0
vv1 vin 0 dc -3.0
* The engine's gmin on every node, beside the gmin ngspice puts across each junction.
rx_gmin_vin vin 0 1000000000000.0
rx_gmin_va va 0 1000000000000.0
.control
save all @dd1[id] @rr1[i]
op
set filetype=ascii
write op.raw all
.endc
.end

* inductor-0805-op: generated by packages/engine/scripts/ngspice_refs.py from netlist.json. Do not edit.
.options temp=25 tnom=25 reltol=1e-9 abstol=1e-15 vntol=1e-12 gmin=1e-12
rx_l1_s mid x_l1 1.0
ll1 x_l1 0 1e-06
rr1 vin mid 10.0
vv1 vin 0 dc 5.0
.control
save all i(ll1) @rr1[i]
op
set filetype=ascii
write op.raw all
.endc
.end

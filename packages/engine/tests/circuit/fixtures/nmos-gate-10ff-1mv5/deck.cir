* nmos-gate-10ff-1mv5: generated by packages/engine/scripts/ngspice_refs.py from netlist.json. Do not edit.
.options temp=25 tnom=25 reltol=1e-9 abstol=1e-15 vntol=1e-12 gmin=1e-12
vx_m1_d d x_m1_d dc 0
vx_m1_g g x_m1_g dc 0
mm1 x_m1_d x_m1_g 0 0 mmod_m1 l=100u w=100u
.model mmod_m1 nmos (level=1 vto=1.08 kp=0.0468 lambda=0.0 is=0)
cm1_gs x_m1_g 0 1e-14
cm1_gd x_m1_g x_m1_d 1e-14
cm1_ds x_m1_d 0 1e-14
rrd vcc d 100.0
rrg in g 1000000000.0
vv1 vcc 0 dc 5.0
vvin in 0 dc 0.0 pwl(0p 0.0 500000000p 0.0 500001000p 0.0015 800000000p 0.0015 800001000p 0.0 1500000000p 0.0)
* The engine's gmin on every node, beside the gmin ngspice puts across each junction.
rx_gmin_d d 0 1000000000000.0
rx_gmin_g g 0 1000000000000.0
rx_gmin_in in 0 1000000000000.0
rx_gmin_vcc vcc 0 1000000000000.0
* One source per ramp corner makes it a breakpoint. ngspice skips a PWL corner it lands on an ulp early.
vbp0 bp0 0 pwl(500000000p 0 500000001p 0)
vbp1 bp1 0 pwl(500001000p 0 500001001p 0)
vbp2 bp2 0 pwl(800000000p 0 800000001p 0)
vbp3 bp3 0 pwl(800001000p 0 800001001p 0)
.control
save v(d) v(g) v(in) v(vcc) i(vv1) i(vvin) i(vx_m1_d) i(vx_m1_g) @rrd[i] @rrg[i]
tran 1000000p 1000000000p 0 1000000p
set filetype=ascii
write tran.raw
.endc
.end

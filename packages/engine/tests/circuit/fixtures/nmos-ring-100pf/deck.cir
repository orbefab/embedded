* nmos-ring-100pf: generated by packages/engine/scripts/ngspice_refs.py from netlist.json. Do not edit.
.options temp=25 tnom=25 reltol=1e-9 abstol=1e-15 vntol=1e-12 gmin=1e-12
vx_m1_d n1 x_m1_d dc 0
vx_m1_g n3 x_m1_g dc 0
mm1 x_m1_d x_m1_g 0 0 mmod_m1 l=100u w=100u
.model mmod_m1 nmos (level=1 vto=1.08 kp=0.0468 lambda=0.0 is=0)
cm1_gs x_m1_g 0 1e-10
cm1_gd x_m1_g x_m1_d 1e-10
cm1_ds x_m1_d 0 1e-10
vx_m2_d n2 x_m2_d dc 0
vx_m2_g n1 x_m2_g dc 0
mm2 x_m2_d x_m2_g 0 0 mmod_m2 l=100u w=100u
.model mmod_m2 nmos (level=1 vto=1.08 kp=0.0468 lambda=0.0 is=0)
cm2_gs x_m2_g 0 1e-10
cm2_gd x_m2_g x_m2_d 1e-10
cm2_ds x_m2_d 0 1e-10
vx_m3_d n3 x_m3_d dc 0
vx_m3_g n2 x_m3_g dc 0
mm3 x_m3_d x_m3_g 0 0 mmod_m3 l=100u w=100u
.model mmod_m3 nmos (level=1 vto=1.08 kp=0.0468 lambda=0.0 is=0)
cm3_gs x_m3_g 0 1e-10
cm3_gd x_m3_g x_m3_d 1e-10
cm3_ds x_m3_d 0 1e-10
rr1 vcc n1 100000.0
rr2 vcc n2 100000.0
rr3 vcc n3 100000.0
rrk k n1 1000000.0
vv1 vcc 0 dc 5.0
vvk k 0 dc 0.0 pwl(0p 0.0 1000000p 0.0 1001000p 5.0 3000000p 5.0 3001000p 0.0 601000000p 0.0)
* The engine's gmin on every node, beside the gmin ngspice puts across each junction.
rx_gmin_k k 0 1000000000000.0
rx_gmin_n1 n1 0 1000000000000.0
rx_gmin_n2 n2 0 1000000000000.0
rx_gmin_n3 n3 0 1000000000000.0
rx_gmin_vcc vcc 0 1000000000000.0
* One source per ramp corner makes it a breakpoint. ngspice skips a PWL corner it lands on an ulp early.
vbp0 bp0 0 pwl(1000000p 0 1000001p 0)
vbp1 bp1 0 pwl(1001000p 0 1001001p 0)
vbp2 bp2 0 pwl(3000000p 0 3000001p 0)
vbp3 bp3 0 pwl(3001000p 0 3001001p 0)
.control
save v(k) v(n1) v(n2) v(n3) v(vcc) i(vv1) i(vvk) i(vx_m1_d) i(vx_m1_g) i(vx_m2_d) i(vx_m2_g) i(vx_m3_d) i(vx_m3_g) @rr1[i] @rr2[i] @rr3[i] @rrk[i]
tran 300000p 300000000p 0 300000p
set filetype=ascii
write tran.raw
.endc
.end

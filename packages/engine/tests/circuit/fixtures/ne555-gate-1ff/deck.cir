* ne555-gate-1ff: generated by packages/engine/scripts/ngspice_refs.py from netlist.json. Do not edit.
.options temp=25 tnom=25 reltol=1e-9 abstol=1e-15 vntol=1e-12 gmin=1e-12
cc1 thr 0 1e-08
.ic v(thr)=0.0
vx_m1_d d x_m1_d dc 0
vx_m1_g g x_m1_g dc 0
mm1 x_m1_d x_m1_g 0 0 mmod_m1 l=100u w=100u
.model mmod_m1 nmos (level=1 vto=1.08 kp=0.0468 lambda=0.0 is=0)
cm1_gs x_m1_g 0 1e-15
cm1_gd x_m1_g x_m1_d 1e-15
cm1_ds x_m1_d 0 1e-15
rra vcc dis 1000.0
rrb dis thr 4700.0
rrd vcc d 100.0
rrg out g 2000000000.0
rx_u1_l1 vcc cont 5000.0
rx_u1_l2 cont x_u1_lo 5000.0
rx_u1_l3 x_u1_lo 0 5000.0
rx_u1_sup vcc 0 1875.0
* u1 latch: RESET overrides TRIG, TRIG overrides THRES (SLFS022K Table 6-1).
bx_u1_s x_u1_s 0 v = (V(vcc,0) > 0.7) ? ((V(thr,x_u1_lo) > 0) ? ((V(thr,cont) > 0) ? 0 : (V(x_u1_q) > 0.5 ? 1 : 0)) : 1) : 0
rx_u1_q x_u1_s x_u1_q 1
cx_u1_q x_u1_q 0 1e-12
bx_u1_oh vcc out i = (V(x_u1_q) > 0.5) ? (V(vcc,out) - 0.9) / 8.0 : 0
bx_u1_ol out 0 i = (V(x_u1_q) > 0.5) ? 0 : (V(out,0) - 0.016666666666666666) / 16.666666666666668
bx_u1_d dis 0 i = V(dis,0) / ((V(x_u1_q) > 0.5) ? 250000000.0 : 18.75)
vv1 vcc 0 dc 5.0
* The engine's gmin on every node. A chip's ladder holds CONT flat, with no span to hide it.
rx_gmin_vcc vcc 0 1000000000000.0
rx_gmin_dis dis 0 1000000000000.0
rx_gmin_thr thr 0 1000000000000.0
rx_gmin_cont cont 0 1000000000000.0
rx_gmin_out out 0 1000000000000.0
rx_gmin_d d 0 1000000000000.0
rx_gmin_g g 0 1000000000000.0
rx_gmin_x_u1_lo x_u1_lo 0 1000000000000.0
.control
save v(vcc) v(dis) v(thr) v(cont) v(out) v(d) v(g) i(vv1) @cc1[i] i(vx_m1_d) i(vx_m1_g) @rra[i] @rrb[i] @rrd[i] @rrg[i] v(x_u1_q)
tran 200000p 400000000p 0 1000p
set filetype=ascii
write edges.raw v(x_u1_q)
linearize v(vcc) v(dis) v(thr) v(cont) v(out) v(d) v(g) i(vv1) @cc1[i] i(vx_m1_d) i(vx_m1_g) @rra[i] @rrb[i] @rrd[i] @rrg[i]
write tran.raw
.endc
.end

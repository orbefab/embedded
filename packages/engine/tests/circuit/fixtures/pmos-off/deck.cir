* pmos-off: generated by packages/engine/scripts/ngspice_refs.py from netlist.json. Do not edit.
.options temp=25 tnom=25 reltol=1e-9 abstol=1e-15 vntol=1e-12 gmin=1e-12
vx_m1_d d x_m1_d dc 0
vx_m1_g g x_m1_g dc 0
mm1 x_m1_d x_m1_g 0 0 mmod_m1 l=100u w=100u
.model mmod_m1 pmos (level=1 vto=-1.08 kp=0.0468 lambda=0.0 is=0)
cm1_gs x_m1_g 0 5.5e-11
cm1_gd x_m1_g x_m1_d 5e-12
cm1_ds x_m1_d 0 2e-11
rrd vcc d 1000.0
vv1 vcc 0 dc -5.0
vvg g 0 dc 0.0
* The engine's gmin on every node, beside the gmin ngspice puts across each junction.
rx_gmin_d d 0 1000000000000.0
rx_gmin_g g 0 1000000000000.0
rx_gmin_vcc vcc 0 1000000000000.0
.control
save all i(vx_m1_d) i(vx_m1_g) @rrd[i]
op
set filetype=ascii
write op.raw all
.endc
.end

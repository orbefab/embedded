* regulator-rdo-1: generated by packages/engine/scripts/ngspice_refs.py from netlist.json. Do not edit.
.options temp=25 tnom=25 reltol=1e-9 abstol=1e-15 vntol=1e-12 gmin=1e-12
.func sp(x) {ln(1+exp(-abs(x))) + (x>0 ? x : 0)}
.func smin(a,b) {a - 1e-3*sp((a-b)/1e-3)}
.func h(x) {x<=0 ? 0 : (x>=1 ? 1 : x*x*(3-2*x))}
cc1 vout 0 1e-05
rrl vout 0 330.0
rrl2 ld 0 6.6
ssw1 vout ld ctl_sw1 0 swmod_sw1
.model swmod_sw1 sw (vt=0.5 vh=0 ron=0.01 roff=1000000000.0)
vctl_sw1 ctl_sw1 0 pwl(0p 0 1000000000p 0 1000001000p 1 3000000000p 1 3000001000p 0)
bx_u1_v x_u1 0 v = smin((3.3+9.75609756097561e-05*(v(vin,0)-3.3)-0.00125*i(vx_u1)), (-0.25*i(vx_u1)+1e-3*sp(((v(vin,0)-0.1-1.0*i(vx_u1))+0.25*i(vx_u1))/1e-3))) - 275.0*0.0012*sp((i(vx_u1)-1.2)/0.0012) + 1000000000.0*1e-12*sp(-i(vx_u1)/1e-12)
vx_u1 x_u1 vout dc 0
fx_u1 vin 0 vx_u1 1
bx_u1_g x_u1_g 0 i = (0.005+0.0*i(vx_u1))*h(v(vin,0)/0.1)+0.005*(v(vin,0))/0.1*h(-(v(vin,0))/0.1)
vx_u1_g vin x_u1_g dc 0
vv1 vin 0 dc 0.0 pwl(0p 0.0 1000p 0.0 2000p 5.0)
* The engine's gmin on every external node. The regulator's internal nodes are not shunted.
rx_gmin_ld ld 0 1000000000000.0
rx_gmin_vin vin 0 1000000000000.0
rx_gmin_vout vout 0 1000000000000.0
* One source per ramp corner makes it a breakpoint. ngspice skips a PWL corner it lands on an ulp early.
vbp0 bp0 0 pwl(1000p 0 1001p 0)
vbp1 bp1 0 pwl(2000p 0 2001p 0)
vbp2 bp2 0 pwl(1000000000p 0 1000000001p 0)
vbp3 bp3 0 pwl(1000001000p 0 1000001001p 0)
vbp4 bp4 0 pwl(3000000000p 0 3000000001p 0)
vbp5 bp5 0 pwl(3000001000p 0 3000001001p 0)
.control
save v(ld) v(vin) v(vout) i(vv1) @cc1[i] @rrl[i] @rrl2[i] @ssw1[i] i(vx_u1) i(vx_u1_g)
tran 5000000p 5000000000p 0 5000000p
set filetype=ascii
write tran.raw
.endc
.end

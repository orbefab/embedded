* pnp-reverse: generated by packages/engine/scripts/ngspice_refs.py from netlist.json. Do not edit.
.options temp=25 tnom=25 reltol=1e-9 abstol=1e-15 vntol=1e-12 gmin=1e-12
vx_q1_c c x_q1_c dc 0
vx_q1_b b x_q1_b dc 0
qq1 x_q1_c x_q1_b e qmod_q1
.model qmod_q1 pnp (is=1e-08 bf=173.2 br=0.7185 nf=1.0 nr=1.0 vaf=100.0 rb=4.068 rc=1.041 re=0.495 cje=1e-11 cjc=4.5e-12 mje=0 mjc=0)
vvb b 0 dc 0.0
vvc c 0 dc -0.13
vve e 0 dc 0.0
* The engine's gmin on every node, beside the gmin ngspice puts across each junction.
rx_gmin_b b 0 1000000000000.0
rx_gmin_c c 0 1000000000000.0
rx_gmin_e e 0 1000000000000.0
.control
save all i(vx_q1_c) i(vx_q1_b)
op
set filetype=ascii
write op.raw all
.endc
.end

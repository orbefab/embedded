* i2c-rc-bus: generated by packages/engine/scripts/ngspice_refs.py from netlist.json. Do not edit.
.options temp=25 tnom=25 reltol=1e-9 abstol=1e-15 vntol=1e-12 gmin=1e-12
ccscl scl 0 2e-10
ccsda sda 0 2e-10
rrscl vcc scl 4700.0
rrsda vcc sda 4700.0
sswscl scl 0 ctl_swscl 0 swmod_swscl
.model swmod_swscl sw (vt=0.5 vh=0 ron=0.1 roff=1000000000.0)
vctl_swscl ctl_swscl 0 pwl(0p 0 9500000p 0 9501000p 1 15000000p 1 15001000p 0 19500000p 0 19501000p 1 25000000p 1 25001000p 0 29500000p 0 29501000p 1 35000000p 1 35001000p 0)
sswsda sda 0 ctl_swsda 0 swmod_swsda
.model swmod_swsda sw (vt=0.5 vh=0 ron=0.1 roff=1000000000.0)
vctl_swsda ctl_swsda 0 pwl(0p 0 5000000p 0 5001000p 1 10000000p 1 10001000p 0 20000000p 0 20001000p 1 39500000p 1 39501000p 0)
vv1 vcc 0 dc 5.0
* One source per ramp corner makes it a breakpoint. ngspice skips a PWL corner it lands on an ulp early.
vbp0 bp0 0 pwl(5000000p 0 5000001p 0)
vbp1 bp1 0 pwl(5001000p 0 5001001p 0)
vbp2 bp2 0 pwl(9500000p 0 9500001p 0)
vbp3 bp3 0 pwl(9501000p 0 9501001p 0)
vbp4 bp4 0 pwl(10000000p 0 10000001p 0)
vbp5 bp5 0 pwl(10001000p 0 10001001p 0)
vbp6 bp6 0 pwl(15000000p 0 15000001p 0)
vbp7 bp7 0 pwl(15001000p 0 15001001p 0)
vbp8 bp8 0 pwl(19500000p 0 19500001p 0)
vbp9 bp9 0 pwl(19501000p 0 19501001p 0)
vbp10 bp10 0 pwl(20000000p 0 20000001p 0)
vbp11 bp11 0 pwl(20001000p 0 20001001p 0)
vbp12 bp12 0 pwl(25000000p 0 25000001p 0)
vbp13 bp13 0 pwl(25001000p 0 25001001p 0)
vbp14 bp14 0 pwl(29500000p 0 29500001p 0)
vbp15 bp15 0 pwl(29501000p 0 29501001p 0)
vbp16 bp16 0 pwl(35000000p 0 35000001p 0)
vbp17 bp17 0 pwl(35001000p 0 35001001p 0)
vbp18 bp18 0 pwl(39500000p 0 39500001p 0)
vbp19 bp19 0 pwl(39501000p 0 39501001p 0)
.control
save v(scl) v(sda) v(vcc) i(vv1) @ccscl[i] @ccsda[i] @rrscl[i] @rrsda[i] @sswscl[i] @sswsda[i]
tran 50000p 50000000p 0 50000p
set filetype=ascii
write tran.raw
.endc
.end

* led-reverse: generated by packages/engine/scripts/ngspice_refs.py from netlist.json. Do not edit.
.options temp=25 tnom=25 reltol=1e-9 abstol=1e-15 vntol=1e-12 gmin=1e-12
dled1 a c dmod_led1
.model dmod_led1 d (is=6.711e-10 n=4.427 rs=2.115)
vva a 0 dc 5.0
vvc c 0 dc 5.5
* The engine's gmin on every node, beside the gmin ngspice puts across each junction.
rx_gmin_a a 0 1000000000000.0
rx_gmin_c c 0 1000000000000.0
.control
save all @dled1[id]
op
set filetype=ascii
write op.raw all
.endc
.end
